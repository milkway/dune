* netlist extracted by dune-pic
Vdd Vp 0 dc 3.3
Vin In 0 dc 0 pulse(0 3.3 2n 1n 1n 8n 20n)
MN1 Out1 In 0 0 n3 l=1u w=4u ad=8p as=8p pd=12u ps=12u
MP1 Out1 In Vp Vp p3 l=1u w=10u ad=20p as=20p pd=24u ps=24u
C3 Out1 0 50f
MN2 Out2 Out1 0 0 n3 l=1u w=4u ad=8p as=8p pd=12u ps=12u
MP2 Out2 Out1 Vp Vp p3 l=1u w=10u ad=20p as=20p pd=24u ps=24u
C4 Out2 0 100f
Vac Ain 0 dc 0 ac 1
Cin Ain Vg 10p
RF Vd Vg 200k
MN3 Vd Vg Vs 0 n3 l=2u w=20u ad=40p as=40p pd=44u ps=44u
RS3 Vs 0 500
RL Vp Vd 10k
C7 Vd 0 0.2p
.model n3 nmos level=3 vto=0.6 nsub=4e16 tox=1.5e-8 xj=0.15u ld=0.05u u0=450
+ theta=0.06 eta=0.2 delta=0.6 vmax=1.6e5 kappa=0.4 nfs=6e11 rsh=15
+ cj=4e-4 mj=0.45 cjsw=3e-10 mjsw=0.3 cgso=2e-10 cgdo=2e-10 cgbo=1e-10
.model p3 pmos level=3 vto=-0.7 nsub=3e16 tox=1.5e-8 xj=0.2u ld=0.06u u0=180
+ theta=0.05 eta=0.15 delta=0.5 kappa=0.6 nfs=4e11 rsh=25
+ cj=5e-4 mj=0.5 cjsw=3.5e-10 mjsw=0.33 cgso=2.5e-10 cgdo=2.5e-10 cgbo=1e-10
.ac dec 10 10k 10g
.op
.tran 0.1n 40n
.end
