* netlist extracted by dune-pic
XNDINV1 In N11 N12 N13 N2 Vp NDINV
XNDINV2 N2 N21 N22 N23 N3 Vp NDINV
XNDINV3 N3 N31 N32 N33 N4 Vp NDINV
XNDINV4 N4 N41 N42 N43 N5 Vp NDINV
VDD Vp 0 5
VIN In 0 DC 0 PWL(0 0 2N 5)
.include mos6inv_sub.sub
.TRAN 0.5N 150N
.PRINT TRAN V(In) V(N2) V(N3) V(N4) V(N5)
.PRINT TRAN V(N11) V(N12) V(N13) V(N41) V(N42) V(N43)
.OPTIONS ACCT
.end
