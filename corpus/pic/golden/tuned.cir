* netlist extracted by dune-pic
V1 In 0 AC 1
RS In Pri 1k
C1 Pri 0 10n
L1 Pri 0 10u
L2 Vout 0 10u
K1 L1 L2 0.1
C2 Vout 0 10n
RL Vout 0 1k
.ac lin 401 400k 650k
.end
