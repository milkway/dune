* netlist extracted by dune-pic
V1 Va 0 dc 0.9
D1 Va 0 dmod 2.0
D2 Va Vk dmod
R2 Vk 0 50
.model dmod d(is=2.5e-15 rs=4 n=1.2)
.op
.end
