.option scale: MOSFET geometry and bin selection in scaled units
* written for Dune (Fase 8 item 7, G4/G5 of docs/pdk-parser.md): with
* scale=1u, ngspice multiplies l, w (and pd, ps; ad, as by scale^2) of
* MOS levels 1-3 and BSIM3/BSIM4 instances, and L, W in the bin rule,
* but not model parameters (ld stays in meters) nor the bin limits
* (probes s5 b_scale and s6 in .claude/scratch/g3-probes); sky130's
* libraries are written this way
.option scale=1u
.model n1 nmos level=1 vto=0.6 kp=1e-4 ld=0.05u cj=1e-4 cjsw=1e-10
.model nb.1 nmos level=49 version=3.3 lmin=0.1u lmax=1u wmin=1u wmax=10u vth0=0.3 tox=4n
.model nb.2 nmos level=49 version=3.3 lmin=1u lmax=10u wmin=1u wmax=10u vth0=0.6 tox=4n
.subckt dev d g w=1 l=1
m1 d g 0 0 nb l={l} w={w} ad={w*0.5} pd={2*w+1}
.ends
vg g 0 0
vd1 d1 0 1.2
vd2 d2 0 1.2
vd3 d3 0 1.2
m1 d1 g 0 0 n1 l=1 w=4 ad=2 as=2 pd=6 ps=6
x1 d2 g dev w=2 l=0.5
x2 d3 g dev w=3 l=5
.dc vg 0 1.5 0.05
.end
