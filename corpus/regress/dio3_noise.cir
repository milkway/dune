ngspice-47 diode extensions in a noise analysis
* written for Dune: the shot noise of the total junction current
* (bottom, sidewall, recombination, tunnelling) and the flicker term
* KF*|Id/m|^AF*m with AF != 1, plus RS thermal noise scaled by TRS,
* in a diode-loaded common-emitter stage
.temp 45
.model dn d is=1e-14 rs=30 trs=2e-3 jsw=1e-13 isr=1e-12 jtun=1e-14 kf=1e-14 af=1.3 tlev=2
.model qn npn is=1e-16 bf=120
vcc 1 0 10
vin 2 0 dc 0.68 ac 1
q1 3 2 0 qn
rc 1 3 5k
d1 3 4 dn pj=2 m=2
rl 4 0 2k
.noise v(4) vin dec 10 10 100meg 1
.end
