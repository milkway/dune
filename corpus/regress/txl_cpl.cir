KSPICE TXL card turned CPL by its R/L
* Coverage: `inpdomod.c` makes a `txl` model with 1.6e9 < R/L <= 1.6e10
* a CplLines model, and `INP2Y` then hands the Y card to `INP2P`, which
* reads it as a one-conductor P line (R/L = 2e9 here): the CPL setup
* with a 1x1 modal decomposition, `len` taken by INP2P, the CPL load.
* Z0 = 100 ohm, delay 3 ns, R*len = 600 ohm. Spice3 profile. Written
* for the Dune port of ngspice-47's txl and cpl models.
.options compat=spice3
v1 in 0 pulse(0 1 2.0003n 2n 2n 20n 100n)
r1 in a 50
y1 a 0 b 0 ymod len 0.3
r2 b 0 50
.model ymod txl R=2000 L=1e-6 G=0 C=1e-10 length=16
.tran 0.5n 60n 0 0.2003n
.end
