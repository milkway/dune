BJT pole-zero: common-emitter stage with series resistances
* Coverage: .pz through bjtpzld.c. A resistively loaded NPN
* common-emitter stage driven from a source resistance, with RB/RC/RE
* (the series conductances stamped as siemens: the 3f5's bjtpzld.c
* stamps RC*area and RE*area instead, see KNOWN_DIFFS), the
* depletion/diffusion capacitances CJE+TF, CJC split by XCJC (cqbx on
* the external base), and CJS on the substrate. The Miller feedback
* through CJC gives a right-half-plane zero.
vcc 1 0 dc 12
vin 2 0 dc 0.7
rsig 2 3 1k
q1 4 3 5 0 qn
re1 5 0 10
rl 1 4 4.7k
cl 4 0 0.5p
.pz 3 0 4 0 vol pz
.model qn npn is=1e-15 bf=120 br=2 vaf=60 rb=150 rbm=40 irb=1m
+ rc=25 re=4 cje=1.2p vje=0.8 mje=0.4 cjc=0.6p vjc=0.7 mjc=0.35
+ xcjc=0.6 tf=0.25n tr=8n cjs=0.3p
.end
