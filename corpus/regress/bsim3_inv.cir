BSIM3v3.3 CMOS inverter chain and amplifier: capMod 3 charges in .op/.ac/.tran
* Coverage: two inverters from the Berkeley 0.35um BSIM3v3.3.0 cards
* (ngspice-47 examples/mos) switching rail to rail, so the default
* charge-thickness capMod 3 gate charges, the bias-dependent capMod
* overlap charges (CGSL/CGDL default 0 -> constant CGSO/CGDO from
* XJ), and the bottom/sidewall/gate-edge junction charges integrate
* across the whole swing in both drain-source orientations; plus a
* self-biased NMOS amplifier (rf feedback, source degeneration,
* bulk at ground) for gm/gds/gmbs and the Meyer-free capacitance
* matrix in .ac. Every switching node carries >= 50 fF so no
* near-floating node crosses vds=0 on a pulse edge.
vdd 1 0 dc 3.3
vin 2 0 dc 0 pulse(0 3.3 2n 0.5n 0.5n 8n 20n)
mn1 3 2 0 0 n1 l=0.35u w=2u ad=2p as=2p pd=6u ps=6u
mp1 3 2 1 1 p1 l=0.35u w=5u ad=5p as=5p pd=12u ps=12u
c3 3 0 50f
mn2 4 3 0 0 n1 l=0.35u w=2u ad=2p as=2p pd=6u ps=6u
mp2 4 3 1 1 p1 l=0.35u w=5u ad=5p as=5p pd=12u ps=12u
c4 4 0 100f
vac 5 0 dc 0 ac 1
cin 5 6 10p
rf 7 6 200k
mn3 7 6 8 0 n1 l=1u w=20u ad=20p as=20p pd=44u ps=44u
rs3 8 0 200
rl 1 7 5k
c7 7 0 0.2p
.ac dec 10 10k 10g
.op
.tran 0.05n 40n
.model n1 nmos
+Level=        8 version=3.3.0
+Tnom=27.0
+Nch= 2.498E+17  Tox=9E-09 Xj=1.00000E-07
+Lint=9.36e-8 Wint=1.47e-7
+Vth0= .6322    K1= .756  K2= -3.83e-2  K3= -2.612
+Dvt0= 2.812  Dvt1= 0.462  Dvt2=-9.17e-2
+Nlx= 3.52291E-08  W0= 1.163e-6
+K3b= 2.233
+Vsat= 86301.58  Ua= 6.47e-9  Ub= 4.23e-18  Uc=-4.706281E-11
+Rdsw= 650  U0= 388.3203 wr=1
+A0= .3496967 Ags=.1    B0=0.546    B1= 1
+Dwg = -6.0E-09 Dwb = -3.56E-09 Prwb = -.213
+Keta=-3.605872E-02  A1= 2.778747E-02  A2= .9
+Voff=-6.735529E-02  NFactor= 1.139926  Cit= 1.622527E-04
+Cdsc=-2.147181E-05
+Cdscb= 0  Dvt0w =  0 Dvt1w =  0 Dvt2w =  0
+Cdscd =  0 Prwg =  0
+Eta0= 1.0281729E-02  Etab=-5.042203E-03
+Dsub= .31871233
+Pclm= 1.114846  Pdiblc1= 2.45357E-03  Pdiblc2= 6.406289E-03
+Drout= .31871233  Pscbe1= 5000000  Pscbe2= 5E-09 Pdiblcb = -.234
+Pvag= 0 delta=0.01
+Wl =  0 Ww = -1.420242E-09 Wwl =  0
+Wln =  0 Wwn =  .2613948 Ll =  1.300902E-10
+Lw =  0 Lwl =  0 Lln =  .316394
+Lwn =  0
+kt1=-.3  kt2=-.051
+At= 22400
+Ute=-1.48
+Ua1= 3.31E-10  Ub1= 2.61E-19 Uc1= -3.42e-10
+Kt1l=0 Prt=764.3
+vgs_max=4 vds_max=4 vbs_max=4
.model p1 pmos
+Level=        8 version=3.3.0
+Tnom=27.0
+Nch= 3.533024E+17  Tox=9E-09 Xj=1.00000E-07
+Lint=6.23e-8 Wint=1.22e-7
+Vth0=-.6732829 K1= .8362093  K2=-8.606622E-02  K3= 1.82
+Dvt0= 1.903801  Dvt1= .5333922  Dvt2=-.1862677
+Nlx= 1.28e-8  W0= 2.1e-6
+K3b= -0.24 Prwg=-0.001 Prwb=-0.323
+Vsat= 103503.2  Ua= 1.39995E-09  Ub= 1.e-19  Uc=-2.73e-11
+Rdsw= 460  U0= 138.7609
+A0= .4716551 Ags=0.12
+Keta=-1.871516E-03  A1= .3417965  A2= 0.83
+Voff=-.074182  NFactor= 1.54389  Cit=-1.015667E-03
+Cdsc= 8.937517E-04
+Cdscb= 1.45e-4  Cdscd=1.04e-4
+Dvt0w=0.232 Dvt1w=4.5e6 Dvt2w=-0.0023
+Eta0= 6.024776E-02  Etab=-4.64593E-03
+Dsub= .23222404
+Pclm= .989  Pdiblc1= 2.07418E-02  Pdiblc2= 1.33813E-3
+Drout= .3222404  Pscbe1= 118000  Pscbe2= 1E-09
+Pvag= 0
+kt1= -0.25  kt2= -0.032 prt=64.5
+At= 33000
+Ute= -1.5
+Ua1= 4.312e-9 Ub1= 6.65e-19  Uc1= 0
+Kt1l=0
+vgs_max=4 vds_max=4 vbs_max=4
.end
