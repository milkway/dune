A device's own m= on Gummel-Poon Q, J and Z distortion
* written for Dune: bjtdset.c, jfetdset.c and mesdset.c scale the
* saturation currents, resistances and charges by m (the 3f5 has the
* area there), and the small-signal matrix carries m in every stamp
* (bjtacld.c, jfetacld.c, mesacl.c); IM products f1+f2, f1-f2, 2f1-f2.
* Supply and input are Norton equivalents so every vector is a node
* voltage
icc 0 5 12
rcc 5 0 1
iin 0 1 0 distof1 2.5u distof2 2.5u
rs 1 0 1k
cin 1 3 10u
rb1 5 3 82k
rb2 3 0 15k
rc 5 4 4.7k
re 6 0 1k
ce 6 0 100u
q1 4 3 6 0 qmod m=2
cj 4 7 1u
rg 7 0 1meg
j1 5 7 8 jn m=3
rsj 8 0 2k
cz 8 9 1u
rgz 9 10 100k
vgz 10 0 dc -0.5
z1 11 9 0 zn m=2
rz 5 11 1k
.model qmod npn is=1e-15 bf=150 vaf=60 ikf=20m ise=2e-14 ne=1.6
+ br=3 var=20 rb=150 irb=0.2m rbm=30 re=2 rc=15
+ cje=2p vje=0.8 mje=0.35 tf=0.4n cjc=1.5p vjc=0.6 mjc=0.4
.model jn njf vto=-2 beta=1.3e-3 lambda=0.01 rd=20 rs=15 cgs=3p cgd=1.5p
.model zn nmf vto=-1.8 beta=3e-3 b=0.3 alpha=2.5 lambda=0.05 rd=5 rs=5
+ cgs=1p cgd=0.2p
.disto dec 5 1e3 1e8 0.9
.end
