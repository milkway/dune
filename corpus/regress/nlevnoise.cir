NLEV/GDSNOI noise selectors of the MOSFETs and the JFET
* Coverage: the non-default branches of ngspice-47's mos1noi.c,
* mos2noi.c, mos3noi.c and jfetnoi.c: flicker NLEV=0
* KF*|Id|^AF/(f*Leff^2*Cox) on m1, NLEV=1 KF*|Id|^AF/(f*W*Leff*Cox)
* on m2, and the NLEV=3 channel noise
* (2/3)*beta*vgst*(1+a+a^2)/(1+a)*GDSNOI with its flicker in the
* NLEV=2 form on m3 (saturation, a = 0) and m4 (linear region), and on
* the JFET j1 (saturation) and j2 (linear region). m1 has no TOX: the
* tox = 1e-7 fallback of mos1noi.c's Cox.
vdd 1 0 5
vin 2 0 dc 1.5 ac 1
m1 3 2 0 0 nm1 l=2u w=20u nrd=2 nrs=1
rl1 1 3 10k
c12 3 6 1u
rg2 6 7 1meg
vb2 7 0 dc 1.2
m2 4 6 0 0 nm2 l=3u w=30u nrd=1.5 nrs=1.5
rl2 1 4 10k
c23 4 8 1u
rg3 8 9 1meg
vb3 9 0 dc 1.1
m3 5 8 0 0 nm3 l=2u w=10u nrd=1 nrs=2
rl3 1 5 20k
c34 5 10 1u
rg4 10 11 1meg
vb4 11 0 dc 3
m4 12 10 0 0 nm1n3 l=2u w=10u
rl4 1 12 6k
c45 12 13 1u
rg5 13 14 1meg
vb5 14 0 dc -0.8
j1 15 13 0 jn3
rl5 1 15 1.5k
c56 15 16 1u
rg6 16 17 1meg
vb6 17 0 dc 0
j2 18 16 0 jn3
rl6 1 18 20k
.model nm1 nmos level=1 vto=0.8 kp=50u lambda=0.02 rsh=20 ld=0.2u
+ kf=1e-26 af=1.2 nlev=0
.model nm2 nmos level=2 vto=0.7 tox=40n nsub=1e16 uo=600 lambda=0.02
+ rsh=15 ld=0.1u kf=2e-26 af=1 nlev=1
.model nm3 nmos level=3 vto=0.7 tox=30n nsub=1e16 uo=500 theta=0.1
+ rsh=10 rd=5 ld=0.1u kf=5e-27 af=0.8 nlev=3 gdsnoi=1.5
.model nm1n3 nmos level=1 vto=0.8 kp=50u tox=20n lambda=0.02 rd=10 rs=10
+ kf=1e-26 af=1.1 nlev=3 gdsnoi=0.8
.model jn3 njf vto=-2 beta=1.3e-3 lambda=0.01 rd=20 rs=15 kf=1e-17 af=1.1
+ nlev=3 gdsnoi=1.2
.noise v(18) vin dec 10 10 100meg 1
.end
