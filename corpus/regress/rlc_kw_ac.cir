Keyword values on C and L cards (c=, capacitance=, l=, inductance=)
* written for Dune: ngspice-47 aliases, set after the positional
* value so they win over it (probes kw.cases in .claude/scratch/dev-probes/s3)
vin 1 0 dc 0 ac 1
ra 1 2 1k
c1 2 0 c=2u
rb 1 3 1k
c2 3 0 capacitance=2u
rc 1 4 1k
c3 4 0 3u c=1u
rd 1 5 1k
l1 5 0 l=20m
re 1 6 1k
l2 6 0 inductance=20m
rf 1 7 1k
l3 7 0 30m l=10m
.ac dec 10 10 1meg
.end
