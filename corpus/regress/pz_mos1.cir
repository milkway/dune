MOS1 pole-zero: common-source stage and a reversed follower
* Coverage: .pz through mos1pzld.c. m1 is a resistively loaded
* common-source stage driven from a source resistance (Meyer gate
* capacitances, CGSO/CGDO/CGBO overlaps, AD/AS bottom and PD/PS
* sidewall junctions, RD/RS series conductances); m2 follows m1's
* drain with its drain and source pins swapped on the card (vds < 0,
* so the reversed-mode xrev stamps carry the transconductance).
vdd 1 0 dc 5
vin 2 0 dc 1.2
rsig 2 3 10k
m1 4 3 0 0 n1 l=2u w=20u ad=40p as=40p pd=44u ps=44u
rl 1 4 20k
m2 5 4 1 0 n1 l=2u w=40u ad=80p as=80p pd=84u ps=84u
rf 5 0 10k
.pz 3 0 5 0 vol pz
.model n1 nmos level=1 vto=0.7 kp=60u gamma=0.4 phi=0.65 lambda=0.03
+ tox=2e-8 ld=0.1u rd=40 rs=30 cj=3e-4 mj=0.5 cjsw=2.5e-10 mjsw=0.33
+ cgso=2e-10 cgdo=2e-10 cgbo=1e-10
.end
