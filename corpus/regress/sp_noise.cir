S-parameter noise of a BJT common-emitter stage (ngspice .sp DONOISE=1)
* Coverage: the .sp noise correlation matrix Cy (written by ngspice as
* i(Cy_i_j)) from the transistor's shot and thermal generators and the
* bias resistors' thermal noise carried to the ports through the
* adjoint solves, plus the two-port noise parameters NF, NFmin, SOpt
* and Rn at the port-1 reference. The transistor has flicker noise
* (KF=1e-12, comparable to the base shot noise at 2 MHz), which .sp
* drops (N_GAIN path of NevalSrc). Cy itself (~1e-23 A^2/Hz) sits far
* below the comparison's abstol floor, so the gate on the noise path
* is NF/NFmin/Rn/SOpt, which are ratios of Cy entries.
vcc vcc 0 dc 12
v1 p1 0 portnum 1
v2 p2 0 portnum 2 z0 75
cin p1 b 10n
rb1 vcc b 47k
rb2 b 0 10k
q1 c b e qn
re e 0 470
ce e 0 100n
rc vcc c 1k
cout c p2 10n
.model qn npn is=1e-16 bf=120 vaf=60 rb=50 rc=5 re=1 cje=1p cjc=0.5p tf=50p kf=1e-12
.sp oct 2 2meg 64meg 1
.end
