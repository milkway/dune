KSPICE TXL: lossy line between near-matched terminations, pulse
* Coverage: the lossy TXL path (R/L < 1.6e9 so the card stays a TXL,
* R/L >= 5e5 so it is not lossless): the Pade fits of the admittance
* (three real poles) and of the propagation function, the recursive
* convolution of every term, the delayed sources, and the
* integer-picosecond history. Z0 = sqrt(L/C) = 138.5 ohm, delay
* sqrt(LC)*16 = 10.4 ns, R*len = 199 ohm of series loss. The time scale
* keeps the accuracy ruler's references (TMAX/40 = 5 ps) well above the
* picosecond the history is truncated to; edges and TMAX sit off whole
* picoseconds. Spice3 profile: the golden is ngspice's trapezoidal run.
* Written for the Dune port of ngspice-47's txl model.
.options compat=spice3
v1 in 0 pulse(0 1 2.0003n 2n 2n 20n 100n)
r1 in a 138
y1 a 0 b 0 ymod
r2 b 0 138
.model ymod txl R=12.45 L=8.972e-8 G=0 C=4.68e-12 length=16
.tran 0.5n 60n 0 0.2003n
.end
