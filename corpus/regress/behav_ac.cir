Behavioural capacitors and inductors in an AC sweep
* written for Dune: ngspice-47 rewrites C c=(eq) into a G/R/C/V/B
* chain (gCxxx gain 1e9 - with m given the gain becomes m, since
* "%15.8e" followed by "e9" reads as m: the capacitor shrinks 1e9
* times, kept here), C q=(eq) into G/L/B with gain m, and L l=(eq)
* into F/L/B (the F senses the B voltage source); each is biased by
* a DC source and driven through a resistor
vin 1 0 dc 0 ac 1
ia 0 2 1m
ra 1 2 1k
c1 2 0 c='1u*(1+v(2))'
ib 0 3 1m
rb 1 3 1k
c2 3 0 '1u*(1+v(3))' m=2
ic 0 4 1m
rc 1 4 1k
c3 4 0 q='1u*v(4)*(1+v(4))' m=3
vs 6 0 dc 1 ac 0
rs 6 0 200
rd 1 5 1k
l1 5 0 l='10m*(1+i(vs)*50)'
re 1 7 1k
l2 7 8 l='10m*(1+v(6))' m=2
v8 8 0 0
.ac dec 10 10 10meg
.end
