ngspice-47 diode extensions in a temperature sweep
* written for Dune: TLEV=0/1/2 (saturation current, band gap with
* GAP1/GAP2, breakdown voltage with TCV), TLEVC=0/1 (junction
* potential and capacitance with CTA/CTP/TPB/TPHP; the capacitances
* show in the sidewall-dominated reverse current through ISR), TRS,
* TTT1 and TM1; each diode is driven by its own current source and
* the swept vectors are the junction voltages (the reverse-biased
* d6 through 100 Mohm, so its voltage reads its leakage)
.model dt0 d is=1e-14 jsw=1e-13 ns=1.3 xti=3 eg=1.11 bv=5 ibv=1m tcv=2m rs=20 trs=3e-3
.model dt1 d is=1e-14 tlev=1 jsw=1e-13 bv=5 ibv=1m tcv=1e-3 isr=1e-12 m=0.3 tm1=1e-3
.model dt2 d is=1e-14 tlev=2 gap1=4.73e-4 gap2=636 xti=2.5 jsw=1e-13 tlevc=1 vj=0.8 tpb=1.5e-3 isr=1e-12
.model dt3 d level=3 tlevc=1 js=2.75e-3 jsw=6e-10 n=1.29 eg=1.05 xti=2 tref=30 gap1=4.73e-4 gap2=1110 tlev=2 php=0.2 tphp=1e-4 vb=11.7 ibv=1e3 ik=1.3e3
i1 0 1 1m
d1 1 0 dt0
i2 0 2 2m
d2 0 2 dt0
i3 0 3 10u
d3 3 0 dt1
i4 0 4 3m
d4 0 4 dt1
i5 0 5 10u
d5 5 0 dt2
v6 16 0 -2
r6 16 6 100meg
d6 6 0 dt2
i7 0 7 1u
d7 7 0 dt3 area=1e-10 pj=4e-5
i8 0 8 10u
d8 0 8 dt3 area=1e-10 pj=4e-5
.dc temp -40 125 5
.end
