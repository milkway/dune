Behavioural resistors in a DC sweep
* written for Dune: a voltage-dependent resistor with min/max
* (rewritten exactly through u(): the sweep crosses both corners)
* and a pwr() law, each in series with a linear one so the branch
* currents are smooth vectors
.param r0=1k vc1=0.3 vc2=0.05
v1 1 0 0
va 1 2 0
ra 2 3 500
r1 3 0 r='r0*(1+min(abs(v(3))-0.5,0.4)*vc1+pow(min(abs(v(3))-0.5,0.4),2)*vc2)'
vb 1 4 0
rb 4 5 200
r2 5 0 r='{r0}*(1+max(v(5),-0.2)*0.5+pwr(v(5),3)*0.01)'
.dc v1 -3 3 0.05
.end
