A device's own m= on Gummel-Poon Q, J and Z noise (AF != 1)
* written for Dune: ngspice-47 multiplies the noise of a device with
* m by m - thermal of the series resistances and of the channel, shot
* of Ic and Ib, and the flicker density as m*KF*|I|^AF with the
* per-device current (bjtnoise.c, jfetnoi.c, mesnoise.c), which an
* area*m cannot express when AF != 1 (it gives KF*|m*I|^AF)
vcc 1 0 dc 10
vin 2 0 dc 0.65 ac 1
q1 3 2 0 qn m=3
rc1 1 3 2k
cc 3 4 1u
rg 4 0 1meg
j1 5 4 6 jn m=2
rd 1 5 3k
rs 6 0 200
cj 5 7 1u
rg2 7 8 100k
vg2 8 0 dc -0.4
z1 9 7 0 zn area=1.5 m=2
rl 1 9 1k
.model qn npn is=1e-16 bf=120 rb=200 re=1 rc=20 kf=1e-15 af=1.6
.model jn njf vto=-2 beta=1.3e-3 lambda=0.01 rd=20 rs=15 kf=1e-17 af=1.4
.model zn nmf vto=-1.8 beta=3e-3 b=0.3 alpha=2.5 lambda=0.05 rd=5 rs=5
+ kf=1e-16 af=0.8
.noise v(9) vin dec 10 10 100meg 1
.end
