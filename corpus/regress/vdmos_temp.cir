VDMOS temperature: TEMP/DTEMP, TNOM and every temperature coefficient
* Coverage: .options temp=85 against TNOM=25 for the KP exponent MU,
* TCVTH, TKSUBTHRES1/2, TRD1/2, TRS1/2, TRG1, TEXP1 (RQ), TRB1/2 and
* the body-diode IS/VJ/CJO laws (EG, XTI, N); instance TEMP= and DTEMP=
* (m4 gives both: ngspice's VDMOSsetup keeps DTEMP), a TEXP0 drain
* resistance (m5) and a breakdown knee at 31 V matched through
* IBV/NBV at temperature. m4 also names temperature nodes without the
* thermal flag: nothing stamps them and they read 0. Written for the
* Dune port of ngspice-47's vdmos model.
.options temp=85
vd d 0 dc 0
vg g 0 dc 4
m1 d g 0 mm
m2 d g 0 mm temp=-20
m3 d g 0 mm dtemp=40
m4 d g 0 tj tc mm temp=0 dtemp=10
m5 d g 0 mt
.model mm vdmos (rd=0.1 rs=0.05 rg=1 rq=0.2 vq=5 kp=10 vto=3 tcvth=-0.005
+ mu=-1.3 texp1=0.4 trd1=3e-3 trd2=1e-5 trs1=2e-3 trs2=1e-6 trg1=1e-3
+ tksubthres1=1e-3 tksubthres2=1e-6 ksubthres=0.15 bv=30 ibv=1e-6 nbv=1.5
+ rb=0.05 trb1=4e-3 trb2=2e-6 eg=1.2 xti=2.5 n=1.1 is=1e-13 tnom=25 vj=0.9
+ cjo=1n)
.model mt vdmos (rd=0.1 texp0=1.7 kp=10 vto=3 bv=31 ibv=1e-3 rb=0.5)
.dc vd -0.9 31.5 0.1
.end
