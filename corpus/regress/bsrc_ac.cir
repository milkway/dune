B source, AC: the operating-point derivatives as small-signal stamps
* Coverage: asrcacld.c (derivatives stored at MODEINITSMSIG), V= and
* I= forms, v(a,b), i(vsrc), and the f^g derivative with a variable
* exponent (the 3f5 writes ln f' where ngspice has ln f).
v1 1 0 dc 0.6 ac 1
r1 1 2 1k
b1 2 0 i=1e-14*(exp(v(2)/0.0258)-1)
c2 2 0 10p
b2 3 0 v=10*tanh(v(2))+v(2)^2
r3 3 4 1k
c4 4 0 1n
vx 4 5 dc 0
r5 5 0 1k
b3 6 0 v=1k*i(vx)*v(2)+v(3,4)
r6 6 0 1k
b4 0 7 i=1m*v(3,4)^2+1m*(v(2)+1)^v(1)
r7 7 0 1k
c7 7 0 2n
.ac dec 10 1k 1g
.end
