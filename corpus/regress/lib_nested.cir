library with nested sections, one library file read for several sections
* written for Dune (Fase 8 item 7, G1 of docs/pdk-parser.md): section TYP
* of lib/pdk.lib pulls section base of the same file, corner ff of
* lib/corners.lib and lib/params.inc; section extra is a second request
* of the same file
.LIB "lib/pdk.lib" TYP
  .lib lib/pdk.lib extra
vdd 1 0 {vdd}
vin 4 0 0.7
rb 4 2 10k
rl 1 3 {rload*wfac}
q1 3 2 0 qn
d1 3 0 dmod
.dc vin 0 1.8 0.05
.end
