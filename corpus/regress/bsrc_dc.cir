B source, DC: the 3f5 expression functions and v()/i() references
* Coverage: ptfuncs.c functions on both signs of the swept v(1),
* v(a,b), i(vsrc), the e/pi constants, a constant V= source (the
* branch row the 3f5 leaves empty) and a nonlinear I= load that
* Newton has to solve (no limiting, as in asrcload.c).
v1 1 0 dc 0
v2 2 0 dc 1.5
r1 1 0 1k
b1 3 0 v=v(1)*v(2)+sin(v(1))-cos(v(2))/2+atan(v(1))+tanh(2*v(1))
r3 3 0 1k
b2 4 0 v=exp(v(1))+sqrt(v(2))+ln(v(2)+0.5)+abs(v(1)-0.25)+uramp(v(1))+u(v(1)-0.05)
r4 4 0 1k
b3 0 5 i=1m*v(1,2)^2+2*i(v1)+0.5m*sinh(v(1))-0.1m*cosh(v(1))
r5 5 0 1k
b4 6 0 v=asin(v(1)/2)+acos(v(1)/3)+asinh(v(1))+acosh(v(2)+2)+atanh(v(1)/2)+tan(v(1)/2)
r6 6 0 1k
b5 7 0 v=2*pi-e+sgn(v(1))+v(1)^2
r7 7 0 1k
vx 8 9 dc 0
r8 9 0 1k
b6 8 0 v=2^v(2)+(v(2)+1)^v(1)
b7 10 0 i=1e-14*(exp(v(10)/0.0258)-1)-0.1*i(vx)
r10 1 10 2k
b8 11 0 v=2*pi-e
r11 11 0 1k
.dc v1 -1 1 0.05
.end
