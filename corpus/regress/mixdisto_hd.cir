Simple mixer circuit - diffpair fed by modulated Iee (harmonics)
* Derived from spice3f5/examples/mixdisto.cir (in corpus/SKIP: the
* upstream deck keeps its .disto lines commented out, so ngspice -b
* has no analysis to run). This is its first setup, uncommented:
* harmonic analysis with both inputs on DISTOF1. Coverage: BJT .disto
* (bjtdset.c/bjtdisto.c) for ic, ib, qbe (tf), qbc, qsc, three
* transistors with the substrate on vee; the output is v(6).
v1 1 0  0v ac 1.0 distof1 0.001
v2 7 0 0v ac 1.0 distof1 0.001
.disto dec 20 1.0e3 1.0e8

q1 3 1 4 2 mod1
q2 6 0 4 2 mod1
rc1 5 3 10k
rc2 5 6 10k
vcc 5 0 10v
qee 4 7 8 2 mod1
re 8 2 9K
vee 2 0 -10v

.model mod1 npn is=1e-16 bf=100 cjs=2.0e-12 tf=0.3e-9 cje=3.0e-12 cjc=2.0e-12  vaf=50
.end
