LTRA RG line (no L, no C): the frequency-independent attenuator
* Coverage: no corpus deck reaches the RG case; stamped like DC
* with the exp(-sqrt(RG)len) attenuation.
v1 1 0 pulse(0 4 1ns 1ns 1ns 20ns 40ns)
rs 1 2 10
o1 2 0 3 0 lline
rl 3 0 100
.model lline ltra rel=1 r=0.2 g=1e-3 len=24
.tran 0.1ns 60ns
.end
