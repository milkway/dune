AC sensitivity: RLC ladder with coupled inductors and controlled sources
* Coverage: no corpus deck has a .sens card. This pins sens_sens
* (ckt/cktsens.c, AC form) against ngspice-47: at each frequency the
* complex AC system is solved, then each parameter's DEVacLoad stamps
* are differenced and Y^-1 (dI - dY E) / delta is solved against the
* factored complex matrix. The filters keep every R/C/L/V/I/E/F/G/H
* vector, so the deck pins ngspice-47's AC walk of those tables
* (acmag/acphase, the AC-only capacitance and inductance, r_ac), and
* drop only the coupling kab: ngspice-47's AC sensitivity of a K
* coefficient is wrong (3.6e7 here, against -0.256+0.120j from a
* finite difference of two ngspice .ac runs, which Dune matches;
* corpus/KNOWN_DIFFS.md). One frequency on purpose: from the second
* frequency on, ngspice-47 also gets the VCCS/CCCS gains wrong (it
* redoes CKTsetup per frequency; see sens_acsweep.cir), and a
* nonlinear device would enter with gd = capd = 0 for the same reason.
vin 1 0 dc 1 ac 1 30
r1 1 2 1k
l1 2 3 10m
c1 3 0 100n
l2 4 0 5m
kab l1 l2 0.6
r4 4 0 200
i1 0 3 dc 0 ac 0.5m
e1 5 0 3 0 2
r5 5 6 1k
c2 6 0 47n
g1 0 6 4 0 1m
vs 6 7 0
r7 7 0 500
f1 0 8 vs 3
r8 8 9 1k
h1 9 0 vs 100
.sens v(8) r* c* l* v* ?1* ac lin 1 2k 2k
.end
