MOSFET noise: levels 1, 2 and 3 in a capacitively coupled cascade
* Coverage: mos1noi.c/mos2noi.c/mos3noi.c in their ngspice-47 form at
* the default NLEV=2 - RD/RS thermal (here from RSH*NRD/NRS, so the
* #drain/#source prime nodes exist), channel thermal 4kT*(2/3)|gm| and
* the flicker density KF*gm^2/(f^AF*W*Leff*Cox) (the 3f5 used
* KF*|Id|^AF/(f*W*Leff*Cox^2)). nm1 has no TOX, so its flicker term
* falls back to Cox for tox=1e-7 as in mos1noi.c. Each stage is biased
* by its own gate source through 1meg, whose thermal noise also shows.
vdd 1 0 dc 5
vin 2 0 dc 1.5 ac 1
m1 3 2 0 0 nm1 l=2u w=20u nrd=2 nrs=1
rl1 1 3 10k
c12 3 6 1u
rg2 6 7 1meg
vb2 7 0 dc 1.2
m2 4 6 0 0 nm2 l=3u w=30u nrd=1.5 nrs=1.5
rl2 1 4 10k
c23 4 8 1u
rg3 8 9 1meg
vb3 9 0 dc 1.1
m3 5 8 0 0 nm3 l=2u w=10u nrd=1 nrs=2
rl3 1 5 20k
.model nm1 nmos level=1 vto=0.8 kp=50u lambda=0.02 rsh=20 ld=0.2u
+ kf=1e-26 af=1.2
.model nm2 nmos level=2 vto=0.7 tox=40n nsub=1e16 uo=600 lambda=0.02
+ rsh=15 ld=0.1u kf=2e-26 af=1
.model nm3 nmos level=3 vto=0.7 tox=30n nsub=1e16 uo=500 theta=0.1
+ rsh=10 rd=5 ld=0.1u kf=5e-27 af=0.8
.noise v(5) vin dec 10 10 100meg 1
.end
