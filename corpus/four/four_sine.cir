sine through an rc low-pass, fourier
* written for Dune (.four vs ngspice-47); not from Berkeley
* pure sine: THD ~ 0, the fundamental's phase is the RC lag
v1 in 0 sin(0 1 1k)
r1 in out 1k
c1 out 0 100n
.tran 10u 5m
.four 1k v(in) v(out)
.end
