half-wave rectifier with filter cap, periodic steady state
* written for Dune (.pss, issue #13); not from Berkeley
* the circuit of corpus/basic/trdiode.cir; reference: the last
* period of a 200-period .tran (golden, ngspice-47)
*tran-golden: .tran 0.2u 4m 3.978m
* ngspice-47's own .pss lands on the drive here (50.000002 kHz):
*pss-ngspice: 50 1e-3
vin 1 0 sin(0 5 50k)
d1 1 2 dmod
rl 2 0 2k
cf 2 0 100n
.model dmod d(is=1e-14 rs=5 cjo=4p tt=5n)
.pss 50k 20u 2 256 10
.end
