rc low-pass, periodic steady state
* written for Dune (.pss, issue #13); not from Berkeley
* closed form: v(2) = |H| sin(wt + arg H), H = 1/(1 + jwRC), wRC = 2pi
v1 1 0 sin(0 1 1k)
r1 1 2 1k
c1 2 0 1u
.pss 1k 5m 2 128 10
.end
