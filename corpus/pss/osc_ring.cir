three-stage cmos ring oscillator, autonomous periodic steady state
* written for Dune (.pss of autonomous oscillators, issue #20); not from Berkeley
* MOS1 inverters with unequal load caps (10f/11f/12f: the supply
* ramp then leaves the symmetric equilibrium on its own, as on the
* bench). Kick: the PWL supply ramp (not periodic).
*tran-golden: .tran 5p 200n 190n
*tran-golden-vectors: v(1) v(2) v(3)
*pss-ngspice-card: .pss 1.7e9 100e-9 1 1024 10 50 5e-3
vdd vdd 0 pwl(0 0 1n 3.3)
mp1 1 3 vdd vdd pch w=4u l=1u
mn1 1 3 0 0 nch w=2u l=1u
mp2 2 1 vdd vdd pch w=4u l=1u
mn2 2 1 0 0 nch w=2u l=1u
mp3 3 2 vdd vdd pch w=4u l=1u
mn3 3 2 0 0 nch w=2u l=1u
c1 1 0 10f
c2 2 0 11f
c3 3 0 12f
.model nch nmos level=1 vto=0.7 kp=110u gamma=0.4 lambda=0.04 phi=0.7
+ cgso=0.3n cgdo=0.3n cbd=5f cbs=5f
.model pch pmos level=1 vto=-0.7 kp=50u gamma=0.5 lambda=0.05 phi=0.7
+ cgso=0.3n cgdo=0.3n cbd=5f cbs=5f
.pss 0 100n 1 256 10
.end
