colpitts bjt oscillator, autonomous periodic steady state
* written for Dune (.pss of autonomous oscillators, issue #20); the
* circuit and its .pss card are ngspice-47's examples/pss/colpitt_osc_pss.cir
* (an LC tank with a capacitive divider feeding one BJT; ngspice's
* comment predicts about 3.30435 MHz; ngspice converges from the
* card of its colpitt_osc_pss_ctrl.cir, not from the one of the plain
* deck). Kick: the PWL ramp of vee.
*tran-golden: .tran 1n 600u 597u
*tran-golden-vectors: v(3) v(2)
*pss-ngspice-card: .pss 1e6 50e-6 3 256 10 50 5e-3
.model qnl npn(level=1 bf=80 rb=100 ccs=2pf tf=0.3ns tr=6ns cje=3pf cjc=2pf va=50)
r1 1 0 1
q1 2 1 3 qnl
vcc 4 0 5
rl 4 2 750
c1 2 3 500p
c2 4 3 4500p
l1 4 2 5uH
re 3 6 4.65k
vee 6 0 dc -10 pwl 0 0 1e-9 -10
.pss 0 500u 3 256 10
.end
