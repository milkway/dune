pwl and exp sources into rc loads
* written for Dune (Phase 2 .tran parity); not from Berkeley
v1 1 0 pwl(0 0 1u 1 2u 1 3u -1 5u 0)
r1 1 2 1k
c1 2 0 100p
v2 3 0 exp(0 2 0.5u 0.3u 2.5u 0.6u)
r2 3 4 500
c2 4 0 200p
.tran 0.02u 6u
.end
