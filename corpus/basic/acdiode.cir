diode small-signal at forward bias, current-driven
* written for Dune (Phase 2 .ac parity); not from Berkeley
ibias 0 1 dc 1m ac 1m
d1 1 0 dmod
rsh 1 0 100k
.model dmod d(is=1e-14 rs=10 cjo=5p tt=10n vj=0.8 m=0.4)
.ac oct 8 1k 100meg
.end
