nested two-source dc sweep
* written for Dune (Phase 2 .dc parity); not from Berkeley
v1 1 0 dc 0
v2 2 0 dc 0
r1 1 3 1k
r2 2 3 2k
r3 3 0 1k
e1 4 0 3 0 -1.5
r4 4 0 1k
.dc v1 0 1 0.25 v2 0 2 0.5
.end
